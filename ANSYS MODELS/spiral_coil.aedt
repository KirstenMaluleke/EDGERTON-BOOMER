# Ansys Electronics Desktop project, version 2023.2
materials:
  Al-Extruded
  vacuum: permittivity=1
  copper: permeability=0.999991 conductivity=58000000
  aluminum: permeability=1.000021 conductivity=38000000

design Maxwell3DDesign1 (Maxwell 3D, Magnetostatic, model units mm)
geometry:
  PolygonHelix1 [copper] = user_primitive(SegmentedHelix/PolygonHelix.dll, PolygonSegments=0, PolygonRadius=0.6mm, StartHelixRadius=10mm, RadiusChange=1.3mm, Pitch=0mm, Turns=15, SegmentsPerTurn=36, RightHanded=1)
  Polyline1 = polyline(z=0mm, xy in mm: (29.387954, 0) (29.387954, 2) (55, 2), section circle width=1.2mm)
  Polyline2 = polyline(xyz in mm: (9.9621253, 0, 0) (9.9621253, -1, 0) (9.9621253, -1, 4) (55, -1, 4), section circle width=1.2mm)
  PolygonHelix1.unite(Polyline1, Polyline2)
  PolygonHelix1.rotate(axis=X, angle=180deg)
  Region [vacuum] = region(percentage_offset: +X=0, -X=40, +Y=40, -Y=40, +Z=200, -Z=200)
  al2mm [aluminum] = cylinder(axis=Z, base_centre=(0mm, 0mm, 2.6mm), radius=21mm, height=2mm)
boundaries and excitations:
  Current1: Current Faces=PolygonHelix1.face(at (55, -2, 0)) Current=150A IsSolid=true Point_out_of_terminal=false
  Current2: Current Faces=PolygonHelix1.face(at (55, 1, -4)) Current=150A IsSolid=true Point_out_of_terminal=true
parameters:
  Matrix1: Matrix Current1: NumberOfTurns=1
mesh:
  initial mesh: GlobalCurvilinear{Apply}
setups:
  Setup1: Magnetostatic MaximumPasses=10 MinimumPasses=2 MinimumConvergedPasses=1 PercentRefinement=30 PercentError=1 NonLinearResidual=0.001
