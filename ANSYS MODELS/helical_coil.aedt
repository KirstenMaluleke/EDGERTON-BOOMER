# Ansys Electronics Desktop project, version 2023.2
materials:
  Al-Extruded
  vacuum: permittivity=1
  copper: permeability=0.999991 conductivity=58000000
  aluminum: permeability=1.000021 conductivity=38000000

design Maxwell3DDesign1 (Maxwell 3D, Magnetostatic, model units mm)
geometry:
  PolygonHelix1 [copper] = user_primitive(SegmentedHelix/PolygonHelix.dll, PolygonSegments=0, PolygonRadius=1.3mm, StartHelixRadius=30mm, RadiusChange=0mm, Pitch=(2.54*1.3) mm, Turns=21, SegmentsPerTurn=36, RightHanded=1)
  Region [vacuum] = region(percentage_offset: +X=30, -X=30, +Y=0, -Y=0, +Z=30, -Z=30)
  Cylinder1 = cylinder(axis=Y, base_centre=(29.884965mm, 1.4969157e-05mm, 69.341874mm), radius=1.2378998mm, height=89.999985mm)
  Cylinder2 = cylinder(axis=Y, base_centre=(29.885337mm, 0mm, 0.00072757136mm), radius=1.2146791mm, height=-90mm)
  PolygonHelix1.unite(Cylinder1, Cylinder2)
  Cylinder3 [aluminum] = cylinder(axis=Z, base_centre=(0mm, 0mm, 72mm), radius=30mm, height=2mm)
boundaries and excitations:
  Current1: Current Faces=PolygonHelix1.face(at (29.885, 90, 69.3419)) Current=150A IsSolid=true Point_out_of_terminal=false
  Current2: Current Faces=PolygonHelix1.face(at (29.8853, -90, 0.000727571)) Current=150A IsSolid=true Point_out_of_terminal=true
parameters:
  Matrix1: Matrix Current1: NumberOfTurns=1
mesh:
  initial mesh: GlobalCurvilinear{Apply}
setups:
  Setup1: Magnetostatic MaximumPasses=10 MinimumPasses=2 MinimumConvergedPasses=1 PercentRefinement=30 PercentError=1 NonLinearResidual=0.001
